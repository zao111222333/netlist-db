.subckt PM_INVx1_ASAP7_75t_R%A vss 22 10 16 9 3
c1 1 vss 0.00931856f $X=0.072 $Y=0.135
c2 3 vss 0.0887847f $X=0.081 $Y=0.0245
c3 4 vss 0.00717846f $X=0.027 $Y=0.036
c4 5 vss 0.00115785f $X=0.027 $Y=0.135
c5 6 vss 0.00717846f $X=0.027 $Y=0.234
c6 7 vss 0.00713519f $X=0.027 $Y=0.0855
c7 8 vss 0.00713519f $X=0.027 $Y=0.1845
c8 9 vss 0.00205968f $X=0.0412 $Y=0.135
r1 6 8 10.3626 $w=1.39091e-08 $l=4.95e-08 $layer=M1 $thickness=3.6e-08 $X=0.027
+ $Y=0.234 $X2=0.027 $Y2=0.1845
r2 4 7 10.3626 $w=1.39091e-08 $l=4.95e-08 $layer=M1 $thickness=3.6e-08 $X=0.027
+ $Y=0.036 $X2=0.027 $Y2=0.0855
r3 5 9 2.14265 $w=1.61579e-08 $l=1.42e-08 $layer=M1 $thickness=3.6e-08 $X=0.027
+ $Y=0.135 $X2=0.0412 $Y2=0.135
r4 5 7 10.3626 $w=1.39091e-08 $l=4.95e-08 $layer=M1 $thickness=3.6e-08 $X=0.027
+ $Y=0.135 $X2=0.027 $Y2=0.0855
r5 5 8 10.3626 $w=1.39091e-08 $l=4.95e-08 $layer=M1 $thickness=3.6e-08 $X=0.027
+ $Y=0.135 $X2=0.027 $Y2=0.1845
r6 23 24 2.97317 $w=1.3e-08 $l=1.28e-08 $layer=M1 $thickness=3.6e-08 $X=0.0512
+ $Y=0.135 $X2=0.064 $Y2=0.135
r7 22 23 0.991056 $w=1.3e-08 $l=4.2e-09 $layer=M1 $thickness=3.6e-08 $X=0.047
+ $Y=0.1365 $X2=0.0512 $Y2=0.135
r8 22 9 1.34084 $w=1.3e-08 $l=5.8e-09 $layer=M1 $thickness=3.6e-08 $X=0.047
+ $Y=0.1365 $X2=0.0412 $Y2=0.135
r9 20 24 19.3796 $a=3.24e-16 $layer=V0LIG $X=0.063 $Y=0.135 $X2=0.064 $Y2=0.135
r10 1 18 2.6116 $w=2.2e-08 $l=1e-08 $layer=LIG $thickness=4.8e-08 $X=0.072
+ $Y=0.135 $X2=0.082 $Y2=0.135
r11 1 20 4.98695 $w=1.60444e-08 $l=9e-09 $layer=LIG $thickness=4.8e-08 $X=0.072
+ $Y=0.135 $X2=0.063 $Y2=0.135
r12 16 15 14.6259 $w=2.1e-08 $l=4.3e-08 $layer=Gate_1 $thickness=5.6e-08
+ $X=0.081 $Y=0.2025 $X2=0.081 $Y2=0.1595
r13 14 15 2.7211 $w=2.1e-08 $l=8e-09 $layer=Gate_1 $thickness=5.6e-08 $X=0.081
+ $Y=0.1515 $X2=0.081 $Y2=0.1595
r14 13 14 5.79936 $w=2.03333e-08 $l=1.65e-08 $layer=Gate_1 $thickness=5.6e-08
+ $X=0.081 $Y=0.135 $X2=0.081 $Y2=0.1515
r15 13 18 6.27904 $w=2.09e-08 $l=1e-09 $layer=Gate_1 $thickness=5.24e-08
+ $X=0.081 $Y=0.135 $X2=0.082 $Y2=0.135
r16 12 13 5.79936 $w=2.03333e-08 $l=1.65e-08 $layer=Gate_1 $thickness=5.6e-08
+ $X=0.081 $Y=0.1185 $X2=0.081 $Y2=0.135
r17 11 12 2.7211 $w=2.1e-08 $l=8e-09 $layer=Gate_1 $thickness=5.6e-08 $X=0.081
+ $Y=0.1105 $X2=0.081 $Y2=0.1185
r18 10 11 14.6259 $w=2.1e-08 $l=4.3e-08 $layer=Gate_1 $thickness=5.6e-08
+ $X=0.081 $Y=0.0675 $X2=0.081 $Y2=0.1105
r19 10 3 14.6259 $w=2.1e-08 $l=4.3e-08 $layer=Gate_1 $thickness=5.6e-08
+ $X=0.081 $Y=0.0675 $X2=0.081 $Y2=0.0245
.ends

.subckt PM_INVx1_ASAP7_75t_R%Y vss 17 13 25 11 8 7
c1 1 vss 0.00868151f $X=0.108 $Y=0.0675
c2 2 vss 0.00868152f $X=0.108 $Y=0.2025
c3 7 vss 0.0388431f $X=0.0935 $Y=0.0675
c4 8 vss 0.038846f $X=0.0935 $Y=0.2025
c5 9 vss 0.00593248f $X=0.0965 $Y=0.036
c6 10 vss 0.0059601f $X=0.135 $Y=0.234
c7 11 vss 0.00585736f $X=0.135 $Y=0.0795
r1 8 2 0.154321 $w=8.1e-08 $l=1.25e-08 $layer=P_src_drn $thickness=1e-09
+ $X=0.0935 $Y=0.2025 $X2=0.108 $Y2=0.2025
r2 25 8 0.0308642 $w=8.1e-08 $l=2.5e-09 $layer=P_src_drn $thickness=1e-09
+ $X=0.0906 $Y=0.2025 $X2=0.0935 $Y2=0.2025
r3 2 22 19.3796 $a=3.24e-16 $layer=V0LISD $X=0.108 $Y=0.2025 $X2=0.108 $Y2=0.234
r4 22 23 3.14806 $w=1.3e-08 $l=1.35e-08 $layer=M1 $thickness=3.6e-08 $X=0.108
+ $Y=0.234 $X2=0.1215 $Y2=0.234
r5 10 20 10.3626 $w=1.39091e-08 $l=4.95e-08 $layer=M1 $thickness=3.6e-08
+ $X=0.135 $Y=0.234 $X2=0.135 $Y2=0.1845
r6 10 23 1.96775 $w=1.63333e-08 $l=1.35e-08 $layer=M1 $thickness=3.6e-08
+ $X=0.135 $Y=0.234 $X2=0.1215 $Y2=0.234
r7 19 20 11.5429 $w=1.3e-08 $l=4.95e-08 $layer=M1 $thickness=3.6e-08 $X=0.135
+ $Y=0.135 $X2=0.135 $Y2=0.1845
r8 18 19 3.38125 $w=1.3e-08 $l=1.45e-08 $layer=M1 $thickness=3.6e-08 $X=0.135
+ $Y=0.1205 $X2=0.135 $Y2=0.135
r9 17 18 1.39914 $w=1.3e-08 $l=6e-09 $layer=M1 $thickness=3.6e-08 $X=0.1355
+ $Y=0.1145 $X2=0.135 $Y2=0.1205
r10 17 11 8.16164 $w=1.3e-08 $l=3.5e-08 $layer=M1 $thickness=3.6e-08 $X=0.1355
+ $Y=0.1145 $X2=0.135 $Y2=0.0795
r11 11 16 8.96345 $w=1.40345e-08 $l=4.35e-08 $layer=M1 $thickness=3.6e-08
+ $X=0.135 $Y=0.0795 $X2=0.135 $Y2=0.036
r12 15 16 1.96775 $w=1.63333e-08 $l=1.35e-08 $layer=M1 $thickness=3.6e-08
+ $X=0.1215 $Y=0.036 $X2=0.135 $Y2=0.036
r13 14 15 3.14806 $w=1.3e-08 $l=1.35e-08 $layer=M1 $thickness=3.6e-08 $X=0.108
+ $Y=0.036 $X2=0.1215 $Y2=0.036
r14 9 14 2.68168 $w=1.3e-08 $l=1.15e-08 $layer=M1 $thickness=3.6e-08 $X=0.0965
+ $Y=0.036 $X2=0.108 $Y2=0.036
r15 1 14 19.3796 $a=3.24e-16 $layer=V0LISD $X=0.108 $Y=0.0675 $X2=0.108
+ $Y2=0.036
r16 7 1 0.154321 $w=8.1e-08 $l=1.25e-08 $layer=N_src_drn $thickness=1e-09
+ $X=0.0935 $Y=0.0675 $X2=0.108 $Y2=0.0675
r17 13 7 0.0308642 $w=8.1e-08 $l=2.5e-09 $layer=N_src_drn $thickness=1e-09
+ $X=0.0906 $Y=0.0675 $X2=0.0935 $Y2=0.0675
.ends
*
.subckt INVx1_ASAP7_75t_R VSS VDD A Y
*
* VSS VSS
* VDD VDD
* A A
* Y Y
*
*

M0 N_M0_d N_M0_g VSS VSS nmos_rvt L=2e-08 W=8.1e-08 nfin=3 $X=0.071 $Y=0.027
M1 N_M1_d N_M1_g VDD VDD pmos_rvt L=2e-08 W=8.1e-08 nfin=3 $X=0.071 $Y=0.162

* .include "INVx1_ASAP7_75t_R.pex.sp.pxi"

* Start of included file INVx1_ASAP7_75t_R.pex.sp.pxi
x_PM_INVx1_ASAP7_75t_R%A vss A N_M0_g N_M1_g N_A_9 N_A_3 PM_INVx1_ASAP7_75t_R%A
x_PM_INVx1_ASAP7_75t_R%Y vss Y N_M0_d N_M1_d N_Y_11 N_Y_8 N_Y_7
+ PM_INVx1_ASAP7_75t_R%Y
cc_1 N_Y_11 N_A_9 0.00251825f $X=0.135 $Y=0.0795
cc_2 N_Y_8 N_A_3 0.0149941f $X=0.0935 $Y=0.2025
cc_3 N_Y_7 N_A_3 0.0621639f $X=0.0935 $Y=0.0675

* End of included file INVx1_ASAP7_75t_R.pex.sp.pxi
.ends
*
