.DATA inputdata1 MER
+ FILE='file1' p1=1 p2=3 p3=4
+ FILE='file2' p1=1
+ FILE='file3' p1=1
.ENDDATA

.DATA inputdata2 LAM
+ FILE='file1' p1=1 p2=3 p3=4
+ FILE='file2' p1=1
+ FILE='file3' p1=1
+ OUT='file4'
.ENDDATA
