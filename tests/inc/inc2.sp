X0.CCC net8 net23 VSS VPW NHVT11LL_CKT W=0.135u L=40.00n
.lib '../lib.sp' pre_layout
