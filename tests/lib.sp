.option should_not_appear=1
.lib pre_layout
.inc 'cycle_ref0.sp'
.option gmindc=1e-14 scale=0.9
.param prelayout=1
.param flag_cc=1
.params flag=1
.endl pre_layout
