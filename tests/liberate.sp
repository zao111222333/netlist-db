**** Altos spice deck for characterization release dev
*** Arc id: arc22
***           pin opin_dir related related_dir timing_type   table_type      when
*** Info_arc: Q   f        CDN     f           combinational fall_transition CP
** NET-MAP BEGIN for DFCNQD1BWP30P140_0
** NET-MAP END

* begin of instance section for DFCNQD1BWP30P140_0
MM64_0 ml_ax clkbb net176 VSS nch_mac l=3e-08 nf=1 w=1.2e-07
MM76_0 sl_bx sl_a net208 VSS nch_mac l=3e-08 nf=1 w=2.8e-07
MM77_0 sl_bx sl_a VDD VDD pch_mac l=3e-08 nf=1 w=3.4e-07
MM65_0 net176 ml_b net184 VSS nch_mac l=3e-08 nf=1 w=1.2e-07
MM53_0 clkb CP VSS VSS nch_mac l=3e-08 nf=1 w=1.4e-07
MM66_0 net184 CDN VSS VSS nch_mac l=3e-08 nf=1 w=1.2e-07
MM75_0 net208 CDN VSS VSS nch_mac l=3e-08 nf=1 w=2.8e-07
MM78_0 sl_bx CDN VDD VDD pch_mac l=3e-08 nf=1 w=3.4e-07
MM79_0 ml_ax clkb net0138 VDD pch_mac l=3e-08 nf=1 w=1.2e-07
MM4_0 sl_a clkb net0152 VSS nch_mac l=3e-08 nf=1 w=1.65e-07
MM5_0 net0152 sl_bx VSS VSS nch_mac l=3e-08 nf=1 w=1.65e-07
MM2_0 net093 sl_bx VDD VDD pch_mac l=3e-08 nf=1 w=2.95e-07
MM3_0 sl_a clkbb net093 VDD pch_mac l=3e-08 nf=1 w=2.95e-07
MM0_0 ml_b ml_ax VDD VDD pch_mac l=3e-08 nf=1 w=2.95e-07
MSLTp1_0 sl_a clkb ml_b VDD pch_mac l=3e-08 nf=1 w=2.95e-07
MM1_0 ml_b ml_ax VSS VSS nch_mac l=3e-08 nf=1 w=2.6e-07
MSLTn1_0 sl_a clkbb ml_b VSS nch_mac l=3e-08 nf=1 w=2.6e-07
MM60_0 net0138 CDN VDD VDD pch_mac l=3e-08 nf=1 w=1e-07
MM56_0 clkbb clkb VDD VDD pch_mac l=3e-08 nf=1 w=1.7e-07
MM44_0 net103 D VDD VDD pch_mac l=3e-08 nf=1 w=2.95e-07
MM72_0 Q sl_bx VDD VDD pch_mac l=3e-08 nf=1 w=3.4e-07
MM45_0 ml_ax clkbb net103 VDD pch_mac l=3e-08 nf=1 w=2.95e-07
MM61_0 net0138 ml_b VDD VDD pch_mac l=3e-08 nf=1 w=1e-07
MM54_0 clkb CP VDD VDD pch_mac l=3e-08 nf=1 w=1.7e-07
MM46_0 ml_ax clkb net212 VSS nch_mac l=3e-08 nf=1 w=1.85e-07
MM71_0 Q sl_bx VSS VSS nch_mac l=3e-08 nf=1 w=2.8e-07
MM55_0 clkbb clkb VSS VSS nch_mac l=3e-08 nf=1 w=1.4e-07
MM47_0 net212 D VSS VSS nch_mac l=3e-08 nf=1 w=1.85e-07
*RC for wire 0
*RC for wire CDN
*RC for wire clkb
*RC for wire clkbb
*RC for wire CP
*RC for wire D
*RC for wire GND
*RC for wire ml_ax
*RC for wire ml_b
*RC for wire net0138
*RC for wire net0152
*RC for wire net093
*RC for wire net103
*RC for wire net176
*RC for wire net184
*RC for wire net208
*RC for wire net212
*RC for wire Q
*RC for wire sl_a
*RC for wire sl_bx
*RC for wire VDD
*RC for wire VSS

* end of instance section for DFCNQD1BWP30P140_0
VVDD VDD 0 0.8
VVSS VSS 0 0

.temp 25
* .inc '/home/SHARE/Project/LVF_SETUP/char/liberate_demo/input/top.l'

**slew:0.0023**
.param CDN_t0=0.0000000e+00
.param CDN_v0=8.0000000e-01
.param CDN_t1=2.8750000e-12
.param CDN_v1=0.0000000e+00
VCDN CDN 0  pwl(
+ CDN_t0 CDN_v0
+ CDN_t1 CDN_v1)
VCP CP 0  pwl(
+ 0 0.800)
VD D 0  pwl(
+ 0 0.800)
* .ic v(clkb) = 0
* .ic v(clkbb) = 0.8
* .ic v(ml_ax) = 0
* .ic v(ml_b) = 0.8
* .ic v(sl_a) = 0.8
* .ic v(sl_bx) = 0

* **load:0.00015**

* .param Q_cap=1.5000001e-16
* VQ Q altos_25 0
* .print tran v(Q) i(VQ)
* C0_0 altos_25 0 Q_cap

* .ic v(Q) = 0.8

* .param icap_t1=2.8750000e-14

* .param icap_t2=2.8462500e-12
* .meas tran AltosCap INTEG i(VCDN) from='icap_t1' to='icap_t2'

* .param icap_tend0=0.0000000e+00

* .param altos_icap_tend0=0.0000000e+00

* .param icap_tend1=2.8750000e-13
* .meas tran AltosCap1 INTEG i(VCDN) from='icap_tend0' to='icap_tend1'

* .param icap_tend2=8.6249999e-13
* .meas tran AltosCap2 INTEG i(VCDN) from='icap_tend0' to='icap_tend2'

* .param icap_tend3=1.4375000e-12
* .meas tran AltosCap3 INTEG i(VCDN) from='icap_tend0' to='icap_tend3'

* .param icap_tend4=1.7250000e-12
* .meas tran AltosCap4 INTEG i(VCDN) from='icap_tend0' to='icap_tend4'

* .param icap_tend5=2.0125000e-12
* .meas tran AltosCap5 INTEG i(VCDN) from='icap_tend0' to='icap_tend5'

* .param icap_tend6=2.3000000e-12
* .meas tran AltosCap6 INTEG i(VCDN) from='icap_tend0' to='icap_tend6'

* .param icap_tend7=2.5875000e-12
* .meas tran AltosCap7 INTEG i(VCDN) from='icap_tend0' to='icap_tend7'

* .param icap_tend8=2.8747125e-12
* .meas tran AltosCap8 INTEG i(VCDN) from='icap_tend0' to='icap_tend8'

* .param power_tend=2.2107626e-09
* .meas tran AltosLeakCross  trig at=0 targ v(Q) val=0.400000 fall=last
* .meas tran AltosOutputVoltage000 FIND v(Q) AT='power_tend'
* .meas tran AltosPinPower000 INTEG i(VCP) from=0 to='power_tend'
* .meas tran AltosPinPower001 INTEG i(VD) from=0 to='power_tend'
* .meas tran AltosPower000 INTEG i(VVDD) from=0 to='power_tend'
* .meas tran AltosPower001 INTEG i(VVSS) from=0 to='power_tend'

* .meas tran AltosBgnVoltage_ml_ax_000000 FIND v(ml_ax) AT=0
* .meas tran AltosEndVoltage_ml_ax_000000 FIND v(ml_ax) AT='tran_tend-1e-12'

* .meas tran AltosBgnVoltage_sl_bx_000001 FIND v(sl_bx) AT=0
* .meas tran AltosEndVoltage_sl_bx_000001 FIND v(sl_bx) AT='tran_tend-1e-12'

* .meas tran AltosConsLastVoltage FIND v(Q) AT='tran_tend-1e-12'
* .meas tran altosFirstOrlastdelay trig v(CDN) val=0.400000  fall=1 targ v(Q) val=0.400000 fall=1
* .meas tran AltosDelay trig v(CDN) val=0.400000  fall=1 targ v(Q) val=0.400000 fall=last
* .meas tran AltosTransitionFirstOrLast0 trig at=0 targ v(Q) val=0.560000 fall=1
* .meas tran AltosTransitionFirstOrLast1 trig at=0 targ v(Q) val=0.240000 fall=1
* .meas tran AltosTransition0 trig at=0 targ v(Q) val=0.560000 fall=last
* .meas tran AltosTransition1 trig at=0 targ v(Q) val=0.240000 fall=last
* .meas tran AltosECSM000 trig v(CDN) val=0.400000  fall=1 targ v(Q) val=0.784000 fall=last
* .meas tran AltosECSM001 trig v(CDN) val=0.400000  fall=1 targ v(Q) val=0.760000 fall=last
* .meas tran AltosECSM002 trig v(CDN) val=0.400000  fall=1 targ v(Q) val=0.720000 fall=last
* .meas tran AltosECSM003 trig v(CDN) val=0.400000  fall=1 targ v(Q) val=0.640000 fall=last
* .meas tran AltosECSM004 trig v(CDN) val=0.400000  fall=1 targ v(Q) val=0.560000 fall=last
* .meas tran AltosECSM005 trig v(CDN) val=0.400000  fall=1 targ v(Q) val=0.480000 fall=last
* .meas tran AltosECSM006 trig v(CDN) val=0.400000  fall=1 targ v(Q) val=0.400000 fall=last
* .meas tran AltosECSM007 trig v(CDN) val=0.400000  fall=1 targ v(Q) val=0.320000 fall=last
* .meas tran AltosECSM008 trig v(CDN) val=0.400000  fall=1 targ v(Q) val=0.240001 fall=last
* .meas tran AltosECSM009 trig v(CDN) val=0.400000  fall=1 targ v(Q) val=0.160001 fall=last
* .meas tran AltosECSM010 trig v(CDN) val=0.400000  fall=1 targ v(Q) val=0.080001 fall=last
* .meas tran AltosECSM011 trig v(CDN) val=0.400000  fall=1 targ v(Q) val=0.040001 fall=last
* .meas tran AltosECSM012 trig v(CDN) val=0.400000  fall=1 targ v(Q) val=0.016001 fall=last

.option autostop nomod numdgt=6 measdgt=6 ingold=2 measout=0 runlvl=5 itrprt=1

.param tran_tend=2.2118626e-09
.tran 1.00e-12 'tran_tend'  SWEEP data=AltosDataSection

.data AltosDataSection
+ CDN_t0
+ CDN_v0
+ CDN_t1
+ CDN_v1
+ icap_t1
+ icap_t2
+ icap_tend0
+ icap_tend1
+ icap_tend2
+ icap_tend3
+ icap_tend4
+ icap_tend5
+ icap_tend6
+ icap_tend7
+ icap_tend8
+ power_tend
+ Q_cap
+ tran_tend
+ 0.0000000e+00
+ 8.0000000e-01
+ 2.8750000e-12
+ 0.0000000e+00
+ 2.8750000e-14
+ 2.8462500e-12
+ 0.0000000e+00
+ 2.8750000e-13
+ 8.6249999e-13
+ 1.4375000e-12
+ 1.7250000e-12
+ 2.0125000e-12
+ 2.3000000e-12
+ 2.5875000e-12
+ 2.8747125e-12
+ 2.2107626e-09
+ 1.5000001e-16
+ 2.2118626e-09
+ 0.0000000e+00
+ 8.0000000e-01
+ 2.8750000e-12
+ 0.0000000e+00
+ 2.8750000e-14
+ 2.8462500e-12
+ 0.0000000e+00
+ 2.8750000e-13
+ 8.6249999e-13
+ 1.4375000e-12
+ 1.7250000e-12
+ 2.0125000e-12
+ 2.3000000e-12
+ 2.5875000e-12
+ 2.8747125e-12
+ 2.2107626e-09
+ 1.0300000e-15
+ 2.2118626e-09
+ 0.0000000e+00
+ 8.0000000e-01
+ 2.8750000e-12
+ 0.0000000e+00
+ 2.8750000e-14
+ 2.8462500e-12
+ 0.0000000e+00
+ 2.8750000e-13
+ 8.6249999e-13
+ 1.4375000e-12
+ 1.7250000e-12
+ 2.0125000e-12
+ 2.3000000e-12
+ 2.5875000e-12
+ 2.8747125e-12
+ 2.2107626e-09
+ 2.7800000e-15
+ 2.2118626e-09
+ 0.0000000e+00
+ 8.0000000e-01
+ 2.8750000e-12
+ 0.0000000e+00
+ 2.8750000e-14
+ 2.8462500e-12
+ 0.0000000e+00
+ 2.8750000e-13
+ 8.6249999e-13
+ 1.4375000e-12
+ 1.7250000e-12
+ 2.0125000e-12
+ 2.3000000e-12
+ 2.5875000e-12
+ 2.8747125e-12
+ 2.2107626e-09
+ 6.2799998e-15
+ 2.2118626e-09
+ 0.0000000e+00
+ 8.0000000e-01
+ 2.8750000e-12
+ 0.0000000e+00
+ 2.8750000e-14
+ 2.8462500e-12
+ 0.0000000e+00
+ 2.8750000e-13
+ 8.6249999e-13
+ 1.4375000e-12
+ 1.7250000e-12
+ 2.0125000e-12
+ 2.3000000e-12
+ 2.5875000e-12
+ 2.8747125e-12
+ 2.2107626e-09
+ 1.3290000e-14
+ 2.2118626e-09
+ 0.0000000e+00
+ 8.0000000e-01
+ 2.8750000e-12
+ 0.0000000e+00
+ 2.8750000e-14
+ 2.8462500e-12
+ 0.0000000e+00
+ 2.8750000e-13
+ 8.6249999e-13
+ 1.4375000e-12
+ 1.7250000e-12
+ 2.0125000e-12
+ 2.3000000e-12
+ 2.5875000e-12
+ 2.8747125e-12
+ 2.2107626e-09
+ 2.7310001e-14
+ 2.2118626e-09
+ 0.0000000e+00
+ 8.0000000e-01
+ 2.8750000e-12
+ 0.0000000e+00
+ 2.8750000e-14
+ 2.8462500e-12
+ 0.0000000e+00
+ 2.8750000e-13
+ 8.6249999e-13
+ 1.4375000e-12
+ 1.7250000e-12
+ 2.0125000e-12
+ 2.3000000e-12
+ 2.5875000e-12
+ 2.8747125e-12
+ 2.2107626e-09
+ 5.5339999e-14
+ 2.2118626e-09
+ 0.0000000e+00
+ 8.0000000e-01
+ 2.8750000e-12
+ 0.0000000e+00
+ 2.8750000e-14
+ 2.8462500e-12
+ 0.0000000e+00
+ 2.8750000e-13
+ 8.6249999e-13
+ 1.4375000e-12
+ 1.7250000e-12
+ 2.0125000e-12
+ 2.3000000e-12
+ 2.5875000e-12
+ 2.8747125e-12
+ 2.2107626e-09
+ 1.1140000e-13
+ 2.2118626e-09
+ 0.0000000e+00
+ 8.0000000e-01
+ 1.1375000e-11
+ 0.0000000e+00
+ 1.1375000e-13
+ 1.1261250e-11
+ 0.0000000e+00
+ 1.1375000e-12
+ 3.4125000e-12
+ 5.6875001e-12
+ 6.8250001e-12
+ 7.9625001e-12
+ 9.1000001e-12
+ 1.0237500e-11
+ 1.1373863e-11
+ 2.2107626e-09
+ 1.5000001e-16
+ 2.2118626e-09
+ 0.0000000e+00
+ 8.0000000e-01
+ 1.1375000e-11
+ 0.0000000e+00
+ 1.1375000e-13
+ 1.1261250e-11
+ 0.0000000e+00
+ 1.1375000e-12
+ 3.4125000e-12
+ 5.6875001e-12
+ 6.8250001e-12
+ 7.9625001e-12
+ 9.1000001e-12
+ 1.0237500e-11
+ 1.1373863e-11
+ 2.2107626e-09
+ 1.0300000e-15
+ 2.2118626e-09
+ 0.0000000e+00
+ 8.0000000e-01
+ 1.1375000e-11
+ 0.0000000e+00
+ 1.1375000e-13
+ 1.1261250e-11
+ 0.0000000e+00
+ 1.1375000e-12
+ 3.4125000e-12
+ 5.6875001e-12
+ 6.8250001e-12
+ 7.9625001e-12
+ 9.1000001e-12
+ 1.0237500e-11
+ 1.1373863e-11
+ 2.2107626e-09
+ 2.7800000e-15
+ 2.2118626e-09
+ 0.0000000e+00
+ 8.0000000e-01
+ 1.1375000e-11
+ 0.0000000e+00
+ 1.1375000e-13
+ 1.1261250e-11
+ 0.0000000e+00
+ 1.1375000e-12
+ 3.4125000e-12
+ 5.6875001e-12
+ 6.8250001e-12
+ 7.9625001e-12
+ 9.1000001e-12
+ 1.0237500e-11
+ 1.1373863e-11
+ 2.2107626e-09
+ 6.2799998e-15
+ 2.2118626e-09
+ 0.0000000e+00
+ 8.0000000e-01
+ 1.1375000e-11
+ 0.0000000e+00
+ 1.1375000e-13
+ 1.1261250e-11
+ 0.0000000e+00
+ 1.1375000e-12
+ 3.4125000e-12
+ 5.6875001e-12
+ 6.8250001e-12
+ 7.9625001e-12
+ 9.1000001e-12
+ 1.0237500e-11
+ 1.1373863e-11
+ 2.2107626e-09
+ 1.3290000e-14
+ 2.2118626e-09
+ 0.0000000e+00
+ 8.0000000e-01
+ 1.1375000e-11
+ 0.0000000e+00
+ 1.1375000e-13
+ 1.1261250e-11
+ 0.0000000e+00
+ 1.1375000e-12
+ 3.4125000e-12
+ 5.6875001e-12
+ 6.8250001e-12
+ 7.9625001e-12
+ 9.1000001e-12
+ 1.0237500e-11
+ 1.1373863e-11
+ 2.2107626e-09
+ 2.7310001e-14
+ 2.2118626e-09
+ 0.0000000e+00
+ 8.0000000e-01
+ 1.1375000e-11
+ 0.0000000e+00
+ 1.1375000e-13
+ 1.1261250e-11
+ 0.0000000e+00
+ 1.1375000e-12
+ 3.4125000e-12
+ 5.6875001e-12
+ 6.8250001e-12
+ 7.9625001e-12
+ 9.1000001e-12
+ 1.0237500e-11
+ 1.1373863e-11
+ 2.2107626e-09
+ 5.5339999e-14
+ 2.2118626e-09
+ 0.0000000e+00
+ 8.0000000e-01
+ 1.1375000e-11
+ 0.0000000e+00
+ 1.1375000e-13
+ 1.1261250e-11
+ 0.0000000e+00
+ 1.1375000e-12
+ 3.4125000e-12
+ 5.6875001e-12
+ 6.8250001e-12
+ 7.9625001e-12
+ 9.1000001e-12
+ 1.0237500e-11
+ 1.1373863e-11
+ 2.2107626e-09
+ 1.1140000e-13
+ 2.2118626e-09
+ 0.0000000e+00
+ 8.0000000e-01
+ 2.8500000e-11
+ 0.0000000e+00
+ 2.8500000e-13
+ 2.8215000e-11
+ 0.0000000e+00
+ 2.8500000e-12
+ 8.5499999e-12
+ 1.4250000e-11
+ 1.7100000e-11
+ 1.9950000e-11
+ 2.2800000e-11
+ 2.5650000e-11
+ 2.8497150e-11
+ 2.2107626e-09
+ 1.5000001e-16
+ 2.2118626e-09
+ 0.0000000e+00
+ 8.0000000e-01
+ 2.8500000e-11
+ 0.0000000e+00
+ 2.8500000e-13
+ 2.8215000e-11
+ 0.0000000e+00
+ 2.8500000e-12
+ 8.5499999e-12
+ 1.4250000e-11
+ 1.7100000e-11
+ 1.9950000e-11
+ 2.2800000e-11
+ 2.5650000e-11
+ 2.8497150e-11
+ 2.2107626e-09
+ 1.0300000e-15
+ 2.2118626e-09
+ 0.0000000e+00
+ 8.0000000e-01
+ 2.8500000e-11
+ 0.0000000e+00
+ 2.8500000e-13
+ 2.8215000e-11
+ 0.0000000e+00
+ 2.8500000e-12
+ 8.5499999e-12
+ 1.4250000e-11
+ 1.7100000e-11
+ 1.9950000e-11
+ 2.2800000e-11
+ 2.5650000e-11
+ 2.8497150e-11
+ 2.2107626e-09
+ 2.7800000e-15
+ 2.2118626e-09
+ 0.0000000e+00
+ 8.0000000e-01
+ 2.8500000e-11
+ 0.0000000e+00
+ 2.8500000e-13
+ 2.8215000e-11
+ 0.0000000e+00
+ 2.8500000e-12
+ 8.5499999e-12
+ 1.4250000e-11
+ 1.7100000e-11
+ 1.9950000e-11
+ 2.2800000e-11
+ 2.5650000e-11
+ 2.8497150e-11
+ 2.2107626e-09
+ 6.2799998e-15
+ 2.2118626e-09
+ 0.0000000e+00
+ 8.0000000e-01
+ 2.8500000e-11
+ 0.0000000e+00
+ 2.8500000e-13
+ 2.8215000e-11
+ 0.0000000e+00
+ 2.8500000e-12
+ 8.5499999e-12
+ 1.4250000e-11
+ 1.7100000e-11
+ 1.9950000e-11
+ 2.2800000e-11
+ 2.5650000e-11
+ 2.8497150e-11
+ 2.2107626e-09
+ 1.3290000e-14
+ 2.2118626e-09
+ 0.0000000e+00
+ 8.0000000e-01
+ 2.8500000e-11
+ 0.0000000e+00
+ 2.8500000e-13
+ 2.8215000e-11
+ 0.0000000e+00
+ 2.8500000e-12
+ 8.5499999e-12
+ 1.4250000e-11
+ 1.7100000e-11
+ 1.9950000e-11
+ 2.2800000e-11
+ 2.5650000e-11
+ 2.8497150e-11
+ 2.2107626e-09
+ 2.7310001e-14
+ 2.2118626e-09
+ 0.0000000e+00
+ 8.0000000e-01
+ 2.8500000e-11
+ 0.0000000e+00
+ 2.8500000e-13
+ 2.8215000e-11
+ 0.0000000e+00
+ 2.8500000e-12
+ 8.5499999e-12
+ 1.4250000e-11
+ 1.7100000e-11
+ 1.9950000e-11
+ 2.2800000e-11
+ 2.5650000e-11
+ 2.8497150e-11
+ 2.2107626e-09
+ 5.5339999e-14
+ 2.2118626e-09
+ 0.0000000e+00
+ 8.0000000e-01
+ 2.8500000e-11
+ 0.0000000e+00
+ 2.8500000e-13
+ 2.8215000e-11
+ 0.0000000e+00
+ 2.8500000e-12
+ 8.5499999e-12
+ 1.4250000e-11
+ 1.7100000e-11
+ 1.9950000e-11
+ 2.2800000e-11
+ 2.5650000e-11
+ 2.8497150e-11
+ 2.2107626e-09
+ 1.1140000e-13
+ 2.2118626e-09
+ 0.0000000e+00
+ 8.0000000e-01
+ 6.2749999e-11
+ 0.0000000e+00
+ 6.2749999e-13
+ 6.2122499e-11
+ 0.0000000e+00
+ 6.2749999e-12
+ 1.8825000e-11
+ 3.1374999e-11
+ 3.7649999e-11
+ 4.3924999e-11
+ 5.0199999e-11
+ 5.6474999e-11
+ 6.2743724e-11
+ 2.2107626e-09
+ 1.5000001e-16
+ 2.2118626e-09
+ 0.0000000e+00
+ 8.0000000e-01
+ 6.2749999e-11
+ 0.0000000e+00
+ 6.2749999e-13
+ 6.2122499e-11
+ 0.0000000e+00
+ 6.2749999e-12
+ 1.8825000e-11
+ 3.1374999e-11
+ 3.7649999e-11
+ 4.3924999e-11
+ 5.0199999e-11
+ 5.6474999e-11
+ 6.2743724e-11
+ 2.2107626e-09
+ 1.0300000e-15
+ 2.2118626e-09
+ 0.0000000e+00
+ 8.0000000e-01
+ 6.2749999e-11
+ 0.0000000e+00
+ 6.2749999e-13
+ 6.2122499e-11
+ 0.0000000e+00
+ 6.2749999e-12
+ 1.8825000e-11
+ 3.1374999e-11
+ 3.7649999e-11
+ 4.3924999e-11
+ 5.0199999e-11
+ 5.6474999e-11
+ 6.2743724e-11
+ 2.2107626e-09
+ 2.7800000e-15
+ 2.2118626e-09
+ 0.0000000e+00
+ 8.0000000e-01
+ 6.2749999e-11
+ 0.0000000e+00
+ 6.2749999e-13
+ 6.2122499e-11
+ 0.0000000e+00
+ 6.2749999e-12
+ 1.8825000e-11
+ 3.1374999e-11
+ 3.7649999e-11
+ 4.3924999e-11
+ 5.0199999e-11
+ 5.6474999e-11
+ 6.2743724e-11
+ 2.2107626e-09
+ 6.2799998e-15
+ 2.2118626e-09
+ 0.0000000e+00
+ 8.0000000e-01
+ 6.2749999e-11
+ 0.0000000e+00
+ 6.2749999e-13
+ 6.2122499e-11
+ 0.0000000e+00
+ 6.2749999e-12
+ 1.8825000e-11
+ 3.1374999e-11
+ 3.7649999e-11
+ 4.3924999e-11
+ 5.0199999e-11
+ 5.6474999e-11
+ 6.2743724e-11
+ 2.2107626e-09
+ 1.3290000e-14
+ 2.2118626e-09
+ 0.0000000e+00
+ 8.0000000e-01
+ 6.2749999e-11
+ 0.0000000e+00
+ 6.2749999e-13
+ 6.2122499e-11
+ 0.0000000e+00
+ 6.2749999e-12
+ 1.8825000e-11
+ 3.1374999e-11
+ 3.7649999e-11
+ 4.3924999e-11
+ 5.0199999e-11
+ 5.6474999e-11
+ 6.2743724e-11
+ 2.2107626e-09
+ 2.7310001e-14
+ 2.2118626e-09
+ 0.0000000e+00
+ 8.0000000e-01
+ 6.2749999e-11
+ 0.0000000e+00
+ 6.2749999e-13
+ 6.2122499e-11
+ 0.0000000e+00
+ 6.2749999e-12
+ 1.8825000e-11
+ 3.1374999e-11
+ 3.7649999e-11
+ 4.3924999e-11
+ 5.0199999e-11
+ 5.6474999e-11
+ 6.2743724e-11
+ 2.2107626e-09
+ 5.5339999e-14
+ 2.2118626e-09
+ 0.0000000e+00
+ 8.0000000e-01
+ 6.2749999e-11
+ 0.0000000e+00
+ 6.2749999e-13
+ 6.2122499e-11
+ 0.0000000e+00
+ 6.2749999e-12
+ 1.8825000e-11
+ 3.1374999e-11
+ 3.7649999e-11
+ 4.3924999e-11
+ 5.0199999e-11
+ 5.6474999e-11
+ 6.2743724e-11
+ 2.2107626e-09
+ 1.1140000e-13
+ 2.2118626e-09
+ 0.0000000e+00
+ 8.0000000e-01
+ 1.3124999e-10
+ 0.0000000e+00
+ 1.3124999e-12
+ 1.2993749e-10
+ 0.0000000e+00
+ 1.3124999e-11
+ 3.9374998e-11
+ 6.5624996e-11
+ 7.8749995e-11
+ 9.1874995e-11
+ 1.0499999e-10
+ 1.1812499e-10
+ 1.3123687e-10
+ 2.2107626e-09
+ 1.5000001e-16
+ 2.2118626e-09
+ 0.0000000e+00
+ 8.0000000e-01
+ 1.3124999e-10
+ 0.0000000e+00
+ 1.3124999e-12
+ 1.2993749e-10
+ 0.0000000e+00
+ 1.3124999e-11
+ 3.9374998e-11
+ 6.5624996e-11
+ 7.8749995e-11
+ 9.1874995e-11
+ 1.0499999e-10
+ 1.1812499e-10
+ 1.3123687e-10
+ 2.2107626e-09
+ 1.0300000e-15
+ 2.2118626e-09
+ 0.0000000e+00
+ 8.0000000e-01
+ 1.3124999e-10
+ 0.0000000e+00
+ 1.3124999e-12
+ 1.2993749e-10
+ 0.0000000e+00
+ 1.3124999e-11
+ 3.9374998e-11
+ 6.5624996e-11
+ 7.8749995e-11
+ 9.1874995e-11
+ 1.0499999e-10
+ 1.1812499e-10
+ 1.3123687e-10
+ 2.2107626e-09
+ 2.7800000e-15
+ 2.2118626e-09
+ 0.0000000e+00
+ 8.0000000e-01
+ 1.3124999e-10
+ 0.0000000e+00
+ 1.3124999e-12
+ 1.2993749e-10
+ 0.0000000e+00
+ 1.3124999e-11
+ 3.9374998e-11
+ 6.5624996e-11
+ 7.8749995e-11
+ 9.1874995e-11
+ 1.0499999e-10
+ 1.1812499e-10
+ 1.3123687e-10
+ 2.2107626e-09
+ 6.2799998e-15
+ 2.2118626e-09
+ 0.0000000e+00
+ 8.0000000e-01
+ 1.3124999e-10
+ 0.0000000e+00
+ 1.3124999e-12
+ 1.2993749e-10
+ 0.0000000e+00
+ 1.3124999e-11
+ 3.9374998e-11
+ 6.5624996e-11
+ 7.8749995e-11
+ 9.1874995e-11
+ 1.0499999e-10
+ 1.1812499e-10
+ 1.3123687e-10
+ 2.2107626e-09
+ 1.3290000e-14
+ 2.2118626e-09
+ 0.0000000e+00
+ 8.0000000e-01
+ 1.3124999e-10
+ 0.0000000e+00
+ 1.3124999e-12
+ 1.2993749e-10
+ 0.0000000e+00
+ 1.3124999e-11
+ 3.9374998e-11
+ 6.5624996e-11
+ 7.8749995e-11
+ 9.1874995e-11
+ 1.0499999e-10
+ 1.1812499e-10
+ 1.3123687e-10
+ 2.2107626e-09
+ 2.7310001e-14
+ 2.2118626e-09
+ 0.0000000e+00
+ 8.0000000e-01
+ 1.3124999e-10
+ 0.0000000e+00
+ 1.3124999e-12
+ 1.2993749e-10
+ 0.0000000e+00
+ 1.3124999e-11
+ 3.9374998e-11
+ 6.5624996e-11
+ 7.8749995e-11
+ 9.1874995e-11
+ 1.0499999e-10
+ 1.1812499e-10
+ 1.3123687e-10
+ 2.2107626e-09
+ 5.5339999e-14
+ 2.2118626e-09
+ 0.0000000e+00
+ 8.0000000e-01
+ 1.3124999e-10
+ 0.0000000e+00
+ 1.3124999e-12
+ 1.2993749e-10
+ 0.0000000e+00
+ 1.3124999e-11
+ 3.9374998e-11
+ 6.5624996e-11
+ 7.8749995e-11
+ 9.1874995e-11
+ 1.0499999e-10
+ 1.1812499e-10
+ 1.3123687e-10
+ 2.2107626e-09
+ 1.1140000e-13
+ 2.2118626e-09
+ 0.0000000e+00
+ 8.0000000e-01
+ 2.6812499e-10
+ 0.0000000e+00
+ 2.6812499e-12
+ 2.6544374e-10
+ 0.0000000e+00
+ 2.6812499e-11
+ 8.0437496e-11
+ 1.3406249e-10
+ 1.6087499e-10
+ 1.8768749e-10
+ 2.1449999e-10
+ 2.4131249e-10
+ 2.6809817e-10
+ 2.2107626e-09
+ 1.5000001e-16
+ 2.2118626e-09
+ 0.0000000e+00
+ 8.0000000e-01
+ 2.6812499e-10
+ 0.0000000e+00
+ 2.6812499e-12
+ 2.6544374e-10
+ 0.0000000e+00
+ 2.6812499e-11
+ 8.0437496e-11
+ 1.3406249e-10
+ 1.6087499e-10
+ 1.8768749e-10
+ 2.1449999e-10
+ 2.4131249e-10
+ 2.6809817e-10
+ 2.2107626e-09
+ 1.0300000e-15
+ 2.2118626e-09
+ 0.0000000e+00
+ 8.0000000e-01
+ 2.6812499e-10
+ 0.0000000e+00
+ 2.6812499e-12
+ 2.6544374e-10
+ 0.0000000e+00
+ 2.6812499e-11
+ 8.0437496e-11
+ 1.3406249e-10
+ 1.6087499e-10
+ 1.8768749e-10
+ 2.1449999e-10
+ 2.4131249e-10
+ 2.6809817e-10
+ 2.2107626e-09
+ 2.7800000e-15
+ 2.2118626e-09
+ 0.0000000e+00
+ 8.0000000e-01
+ 2.6812499e-10
+ 0.0000000e+00
+ 2.6812499e-12
+ 2.6544374e-10
+ 0.0000000e+00
+ 2.6812499e-11
+ 8.0437496e-11
+ 1.3406249e-10
+ 1.6087499e-10
+ 1.8768749e-10
+ 2.1449999e-10
+ 2.4131249e-10
+ 2.6809817e-10
+ 2.2107626e-09
+ 6.2799998e-15
+ 2.2118626e-09
+ 0.0000000e+00
+ 8.0000000e-01
+ 2.6812499e-10
+ 0.0000000e+00
+ 2.6812499e-12
+ 2.6544374e-10
+ 0.0000000e+00
+ 2.6812499e-11
+ 8.0437496e-11
+ 1.3406249e-10
+ 1.6087499e-10
+ 1.8768749e-10
+ 2.1449999e-10
+ 2.4131249e-10
+ 2.6809817e-10
+ 2.2107626e-09
+ 1.3290000e-14
+ 2.2118626e-09
+ 0.0000000e+00
+ 8.0000000e-01
+ 2.6812499e-10
+ 0.0000000e+00
+ 2.6812499e-12
+ 2.6544374e-10
+ 0.0000000e+00
+ 2.6812499e-11
+ 8.0437496e-11
+ 1.3406249e-10
+ 1.6087499e-10
+ 1.8768749e-10
+ 2.1449999e-10
+ 2.4131249e-10
+ 2.6809817e-10
+ 2.2107626e-09
+ 2.7310001e-14
+ 2.2118626e-09
+ 0.0000000e+00
+ 8.0000000e-01
+ 2.6812499e-10
+ 0.0000000e+00
+ 2.6812499e-12
+ 2.6544374e-10
+ 0.0000000e+00
+ 2.6812499e-11
+ 8.0437496e-11
+ 1.3406249e-10
+ 1.6087499e-10
+ 1.8768749e-10
+ 2.1449999e-10
+ 2.4131249e-10
+ 2.6809817e-10
+ 2.2107626e-09
+ 5.5339999e-14
+ 2.2118626e-09
+ 0.0000000e+00
+ 8.0000000e-01
+ 2.6812499e-10
+ 0.0000000e+00
+ 2.6812499e-12
+ 2.6544374e-10
+ 0.0000000e+00
+ 2.6812499e-11
+ 8.0437496e-11
+ 1.3406249e-10
+ 1.6087499e-10
+ 1.8768749e-10
+ 2.1449999e-10
+ 2.4131249e-10
+ 2.6809817e-10
+ 2.2107626e-09
+ 1.1140000e-13
+ 2.2118626e-09
+ 0.0000000e+00
+ 8.0000000e-01
+ 5.4187497e-10
+ 0.0000000e+00
+ 5.4187497e-12
+ 5.3645622e-10
+ 0.0000000e+00
+ 5.4187497e-11
+ 1.6256249e-10
+ 2.7093749e-10
+ 3.2512498e-10
+ 3.7931248e-10
+ 4.3349998e-10
+ 4.8768748e-10
+ 5.4182079e-10
+ 2.2107626e-09
+ 1.5000001e-16
+ 2.2118626e-09
+ 0.0000000e+00
+ 8.0000000e-01
+ 5.4187497e-10
+ 0.0000000e+00
+ 5.4187497e-12
+ 5.3645622e-10
+ 0.0000000e+00
+ 5.4187497e-11
+ 1.6256249e-10
+ 2.7093749e-10
+ 3.2512498e-10
+ 3.7931248e-10
+ 4.3349998e-10
+ 4.8768748e-10
+ 5.4182079e-10
+ 2.2107626e-09
+ 1.0300000e-15
+ 2.2118626e-09
+ 0.0000000e+00
+ 8.0000000e-01
+ 5.4187497e-10
+ 0.0000000e+00
+ 5.4187497e-12
+ 5.3645622e-10
+ 0.0000000e+00
+ 5.4187497e-11
+ 1.6256249e-10
+ 2.7093749e-10
+ 3.2512498e-10
+ 3.7931248e-10
+ 4.3349998e-10
+ 4.8768748e-10
+ 5.4182079e-10
+ 2.2107626e-09
+ 2.7800000e-15
+ 2.2118626e-09
+ 0.0000000e+00
+ 8.0000000e-01
+ 5.4187497e-10
+ 0.0000000e+00
+ 5.4187497e-12
+ 5.3645622e-10
+ 0.0000000e+00
+ 5.4187497e-11
+ 1.6256249e-10
+ 2.7093749e-10
+ 3.2512498e-10
+ 3.7931248e-10
+ 4.3349998e-10
+ 4.8768748e-10
+ 5.4182079e-10
+ 2.2107626e-09
+ 6.2799998e-15
+ 2.2118626e-09
+ 0.0000000e+00
+ 8.0000000e-01
+ 5.4187497e-10
+ 0.0000000e+00
+ 5.4187497e-12
+ 5.3645622e-10
+ 0.0000000e+00
+ 5.4187497e-11
+ 1.6256249e-10
+ 2.7093749e-10
+ 3.2512498e-10
+ 3.7931248e-10
+ 4.3349998e-10
+ 4.8768748e-10
+ 5.4182079e-10
+ 2.2107626e-09
+ 1.3290000e-14
+ 2.2118626e-09
+ 0.0000000e+00
+ 8.0000000e-01
+ 5.4187497e-10
+ 0.0000000e+00
+ 5.4187497e-12
+ 5.3645622e-10
+ 0.0000000e+00
+ 5.4187497e-11
+ 1.6256249e-10
+ 2.7093749e-10
+ 3.2512498e-10
+ 3.7931248e-10
+ 4.3349998e-10
+ 4.8768748e-10
+ 5.4182079e-10
+ 2.2107626e-09
+ 2.7310001e-14
+ 2.2118626e-09
+ 0.0000000e+00
+ 8.0000000e-01
+ 5.4187497e-10
+ 0.0000000e+00
+ 5.4187497e-12
+ 5.3645622e-10
+ 0.0000000e+00
+ 5.4187497e-11
+ 1.6256249e-10
+ 2.7093749e-10
+ 3.2512498e-10
+ 3.7931248e-10
+ 4.3349998e-10
+ 4.8768748e-10
+ 5.4182079e-10
+ 2.2107626e-09
+ 5.5339999e-14
+ 2.2118626e-09
+ 0.0000000e+00
+ 8.0000000e-01
+ 5.4187497e-10
+ 0.0000000e+00
+ 5.4187497e-12
+ 5.3645622e-10
+ 0.0000000e+00
+ 5.4187497e-11
+ 1.6256249e-10
+ 2.7093749e-10
+ 3.2512498e-10
+ 3.7931248e-10
+ 4.3349998e-10
+ 4.8768748e-10
+ 5.4182079e-10
+ 2.2107626e-09
+ 1.1140000e-13
+ 2.2118626e-09
+ 0.0000000e+00
+ 8.0000000e-01
+ 1.0893750e-09
+ 0.0000000e+00
+ 1.0893750e-11
+ 1.0784812e-09
+ 0.0000000e+00
+ 1.0893750e-10
+ 3.2681250e-10
+ 5.4468749e-10
+ 6.5362499e-10
+ 7.6256249e-10
+ 8.7149999e-10
+ 9.8043749e-10
+ 1.0892661e-09
+ 2.2107626e-09
+ 1.5000001e-16
+ 2.2118626e-09
+ 0.0000000e+00
+ 8.0000000e-01
+ 1.0893750e-09
+ 0.0000000e+00
+ 1.0893750e-11
+ 1.0784812e-09
+ 0.0000000e+00
+ 1.0893750e-10
+ 3.2681250e-10
+ 5.4468749e-10
+ 6.5362499e-10
+ 7.6256249e-10
+ 8.7149999e-10
+ 9.8043749e-10
+ 1.0892661e-09
+ 2.2107626e-09
+ 1.0300000e-15
+ 2.2118626e-09
+ 0.0000000e+00
+ 8.0000000e-01
+ 1.0893750e-09
+ 0.0000000e+00
+ 1.0893750e-11
+ 1.0784812e-09
+ 0.0000000e+00
+ 1.0893750e-10
+ 3.2681250e-10
+ 5.4468749e-10
+ 6.5362499e-10
+ 7.6256249e-10
+ 8.7149999e-10
+ 9.8043749e-10
+ 1.0892661e-09
+ 2.2107626e-09
+ 2.7800000e-15
+ 2.2118626e-09
+ 0.0000000e+00
+ 8.0000000e-01
+ 1.0893750e-09
+ 0.0000000e+00
+ 1.0893750e-11
+ 1.0784812e-09
+ 0.0000000e+00
+ 1.0893750e-10
+ 3.2681250e-10
+ 5.4468749e-10
+ 6.5362499e-10
+ 7.6256249e-10
+ 8.7149999e-10
+ 9.8043749e-10
+ 1.0892661e-09
+ 2.2107626e-09
+ 6.2799998e-15
+ 2.2118626e-09
+ 0.0000000e+00
+ 8.0000000e-01
+ 1.0893750e-09
+ 0.0000000e+00
+ 1.0893750e-11
+ 1.0784812e-09
+ 0.0000000e+00
+ 1.0893750e-10
+ 3.2681250e-10
+ 5.4468749e-10
+ 6.5362499e-10
+ 7.6256249e-10
+ 8.7149999e-10
+ 9.8043749e-10
+ 1.0892661e-09
+ 2.2107626e-09
+ 1.3290000e-14
+ 2.2118626e-09
+ 0.0000000e+00
+ 8.0000000e-01
+ 1.0893750e-09
+ 0.0000000e+00
+ 1.0893750e-11
+ 1.0784812e-09
+ 0.0000000e+00
+ 1.0893750e-10
+ 3.2681250e-10
+ 5.4468749e-10
+ 6.5362499e-10
+ 7.6256249e-10
+ 8.7149999e-10
+ 9.8043749e-10
+ 1.0892661e-09
+ 2.2107626e-09
+ 2.7310001e-14
+ 2.2118626e-09
+ 0.0000000e+00
+ 8.0000000e-01
+ 1.0893750e-09
+ 0.0000000e+00
+ 1.0893750e-11
+ 1.0784812e-09
+ 0.0000000e+00
+ 1.0893750e-10
+ 3.2681250e-10
+ 5.4468749e-10
+ 6.5362499e-10
+ 7.6256249e-10
+ 8.7149999e-10
+ 9.8043749e-10
+ 1.0892661e-09
+ 2.2107626e-09
+ 5.5339999e-14
+ 2.2118626e-09
+ 0.0000000e+00
+ 8.0000000e-01
+ 1.0893750e-09
+ 0.0000000e+00
+ 1.0893750e-11
+ 1.0784812e-09
+ 0.0000000e+00
+ 1.0893750e-10
+ 3.2681250e-10
+ 5.4468749e-10
+ 6.5362499e-10
+ 7.6256249e-10
+ 8.7149999e-10
+ 9.8043749e-10
+ 1.0892661e-09
+ 2.2107626e-09
+ 1.1140000e-13
+ 2.2118626e-09
.enddata

.end

* end of sim.sp
