.param
+ tera=1T
+ giga=1G
+ mega=1meg
+ kilo=1k
+ mil=1mil
+ micr?o=1u
+ nano=1n
+ pico=1p
+ femto=1f
+ atto=1a
+ db0=0db
+ db20=20db
+ db40=40db
+ min=1min
+ hr=1hr
+ day=1day
+ yr=1yr
